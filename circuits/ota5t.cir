* 5T OTA (NMOS 입력 차동쌍 + PMOS 전류 미러 부하), SKY130 1.8V 소자
* 중괄호로 감싼 이름은 eda/spice.py가 채운다 (주석에 중괄호 금지: str.format). W/L 단위 um
.lib {pdk}/libs.tech/ngspice/sky130.lib.spice {corner}
.temp {temp}
VDD vdd 0 1.8
VINP inp 0 DC {vcm} AC 0.5
VINN inn 0 DC {vcm} AC -0.5
IBIAS vdd nbias {ibias}
XMB nbias nbias 0 0 sky130_fd_pr__nfet_01v8 W={wt} L={lt}
XMT tail nbias 0 0 sky130_fd_pr__nfet_01v8 W={wt} L={lt}
XM1 x inp tail 0 sky130_fd_pr__nfet_01v8 W={wn} L={ln}
XM2 out inn tail 0 sky130_fd_pr__nfet_01v8 W={wn} L={ln}
XM3 x x vdd vdd sky130_fd_pr__pfet_01v8 W={wp} L={lp}
XM4 out x vdd vdd sky130_fd_pr__pfet_01v8 W={wp} L={lp}
CL out 0 {cl}
.control
op
let power_w = -i(vdd)*1.8
let vout_dc = v(out)
let vtail = v(tail)
print power_w vout_dc vtail
ac dec 50 1 10G
meas ac gain_db find vdb(out) at=10
meas ac ugf_hz when vdb(out)=0
meas ac phase_ugf find vp(out) at=ugf_hz
let pm_deg = 180 + phase_ugf*180/pi
print pm_deg
.endc
.end
